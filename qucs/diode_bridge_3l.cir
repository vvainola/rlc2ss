* Qucs 1.1.0 C:/Projects/rlc2ss/qucs/diode_bridge_3l.sch
.INCLUDE "C:/Programs/qucs_s_win64/share/qucs-s/xspice_cmlib/include/ngspice_mathfunc.inc"
* Qucs 1.1.0  C:/Projects/rlc2ss/qucs/diode_bridge_3l.sch
V_src_a _net0 0 DC 1
V_src_b _net1 0 DC 1
V_src_c _net2 0 DC 1
S_0_a N_conv_a  N_dc_0  _net4  _net5
S_0_b N_conv_b  N_dc_0  _net6  _net7
S_0_c N_conv_c  N_dc_0  _net8  _net9
V_dc_src _net22 _net23 DC 1
R_dc_src_p _net25 _net24  1E3
L_dc_src _net22 _net24  10E-6
R_dc_pp2 _net25 _net27  1E3
R_dc_pn2 _net27 _net23  1E3
R_dc_sp2 _net25 _net26  1E-3
R_dc_sn2 _net27 _net28  1E-3
R_dc_pp1 N_dc_p N_dc_0  1E3
R_dc_pn1 N_dc_0 N_dc_n  1E3
R_dc_sp1 N_dc_p _net3  1E-3
R_dc_sn1 N_dc_0 _net29  1E-3
C_dc_p2 _net26 _net27  10E-3
C_dc_p1 _net3 N_dc_0  10E-3
C_dc_n1 _net29 N_dc_n  10E-3
C_dc_n2 _net28 _net23  10E-3
L_dc_n _net23 N_dc_n  1E-6
L_dc_p _net25 N_dc_p  1E-6
R_conv_a N_conv_a V2_a  1E-3
R_conv_b N_conv_b V2_b  1E-3
R_conv_c N_conv_c V2_c  1E-3
R_grid_a N_cap_a _net10  1E-3
R_grid_b N_cap_b _net12  1E-3
R_grid_c N_cap_c _net14  1E-3
R_src_a _net11 _net16  1E-3
R_src_b _net13 _net17  1E-3
R_src_c _net15 _net18  1E-3
L_conv_a V2_a N_cap_a  1E-6
L_conv_b V2_b N_cap_b  1E-6
L_conv_c V2_c N_cap_c  1E-6
L_grid_a _net10 _net11  1E-6
L_grid_b _net12 _net13  1E-6
L_grid_c _net14 _net15  1E-6
L_src_a _net16 _net0  1E-6
L_src_b _net17 _net1  1E-6
L_src_c _net18 _net2  1E-6
R_f_a _net19 N_cap_0  1E-3
R_f_b _net20 N_cap_0  1E-3
R_f_c _net21 N_cap_0  1E-3
C_f_a N_cap_a _net19  1E-3
C_f_b N_cap_b _net20  1E-3
C_f_c N_cap_c _net21  1E-3
D_p_a N_conv_a  N_dc_p
D_p_b N_conv_b  N_dc_p
D_p_c N_conv_c  N_dc_p
D_n_a N_dc_n  N_conv_a
D_n_b N_dc_n  N_conv_b
D_n_c N_dc_n  N_conv_c
R_dc_src_s _net25 _net24  1
.control
set filetype=ascii
op
print all > spice4qucs.cir.dc_op
destroy all
quit
.endc
.end
