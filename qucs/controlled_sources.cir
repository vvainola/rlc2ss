* Qucs 1.1.0 C:/Projects/rlc2ss/qucs/controlled_sources.sch
.INCLUDE "C:/Programs/qucs_s_win64/share/qucs-s/xspice_cmlib/include/ngspice_mathfunc.inc"
* Qucs 1.1.0  C:/Projects/rlc2ss/qucs/controlled_sources.sch
L1 _net0 _net1  1e-3;
R2 _net2 0  1;
C_1 _net3 _net2  100e-6;
GSRC1 _net3 _net4 _net0 _net1 1
R3 _net5 _net1  1;
R4 _net6 _net7  1;
V1 _net8 _net9 DC 1
R1 _net8 _net10  1;
ESRC3 _net10 _net0 _net2 _net3 1
R5 _net11 _net9  1;
FSRC5 _net7 _net1  VSRC5 1
VSRC5 0 _net4 DC 0
HSRC4 0 _net5  VSRC4 1
VSRC4 0 _net11 DC 0
R7 _net6 _net5  1E3;
R6 _net6 _net5  1E3;
C_2 _net6 _net5  100E-6;I;
.control
set filetype=ascii
op
print all > spice4qucs.cir.dc_op
destroy all
quit
.endc
.end
